`include "constants.vams"
`include "disciplines.vams"

module three_pole_opamp(vina, vinb, vouta, voutb);

    inout  vina, vinb, vouta, voutb;
    electrical vina, vinb, vouta, voutb;

    parameter real f            = 100M; // Signal Frequency (Hz)
    parameter real f1           = 100M; // First pole frequency (Hz)
    parameter real f2           = 200M; // First pole frequency (Hz)
    parameter real f3           = 300M; // First pole frequency (Hz)
    parameter real A            = 1000; // Gain
    parameter integer mismatch  = 1;    // enables mismatch.
    parameter integer procVar = 1;    // enables process variation.
    parameter real procVal    = 0.2;  // process variation parameter.

    localparam integer seed = 5;

    real w1, w2, w3;                // Frequencies (radians)
    real A_final;                   // Adjusted gain
    real denom[0:3];

    // Process variation will adjust gain
    analog initial begin
        if(procVar == 1) begin
            if(mismatch == 1) begin
                A_final = A * (1.0 + procVal + 0.10 * $rdist_uniform(seed, 0, 1));
            end else begin
                A_final = A * (1.0 + procVal);
            end
            end
        else begin
            A_final = A;
        end
    end

  analog begin

    w1 = 2 * 3.14159 * f1;
    w2 = 2 * 3.14159 * f2;
    w3 = 2 * 3.14159 * f3;

    denom[0] = 1.0;
    denom[1] = 1.0/w1 + 1.0/w2 + 1.0/w3;
    denom[2] = 1.0/(w1*w2) + 1.0/(w1*w3) + 1.0/(w2*w3);
    denom[3] = 1.0/(w1*w2*w3);

    V(vouta, voutb) <+ laplace_nd(A_final * V(vina, vinb), , denom);

end

endmodule
