`include "constants.vams"
`include "disciplines.vams"

module ssamp(vina, vinb, vouta, voutb);

    inout  vina, vinb, vouta, voutb;
    electrical vina, vinb, vouta, voutb;

    parameter real f          = 100M; // Desired pole frequency in [Hz]
    parameter real A          = 300;  // DC Gain
    parameter real C          = 1;    // Load capcitance [Farads].
    parameter real R          = 1;    // Input resistance [Ohms].
    parameter integer mmatch  = 1;    // enables mismatch.
    parameter integer procVar = 1;    // enables process variation.
    parameter real procVal    = 0.2;  // process variation parameter.

    localparam integer seed = 5;

    real CL;  // load capacitance post mismtach and process variation.
    real Rin; // input resistance post mismtach and process variation.
    real txn_func; // transfer function.

  // tox, width and length adjustments for process and device mismatch
  analog initial begin
    if(procVar == 1) begin
      if(mmatch == 1) begin
        CL = C*(1 + procVal + 0.10*$rdist_uniform(seed,0, 1));
        Rin = R*(1 + procVal  + 0.10*$rdist_uniform(seed,0, 1));
      end else begin
        CL = C*(1.0 + procVal);
        Rin = R*(1.0 + procVal);
      end
    end else begin
      CL = C;
      Rin = R;
    end
  end

  analog begin
    if(analysis("ac"))
      txn_func = A/(1+(Rin*CL*2*3.14159*f));
    else
      txn_func = A;
    V(vouta, voutb) <+ txn_func*V(vina, vinb);
  end

endmodule
